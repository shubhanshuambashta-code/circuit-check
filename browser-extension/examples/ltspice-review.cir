* Example with a zero resistor
V1 VCC 0 5
R1 VCC 0 0
.op
.end
